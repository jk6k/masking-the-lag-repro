* SUDS TETC R12h ADC macro corner deck
* Evidence label: adc_macro_corner_spice
* Boundary: Open-source ADC macro corner evidence for ADC-tier calibration only; not PDK, foundry, extracted-layout, silicon, measured hardware energy, photonic front-end, or SPICE closure.

.temp 125.000000
.param VDD=0.90000000
.param BITS=8
.param FS_GSPS=4
.param NCONV=128

Vvdd vdd 0 {VDD}
Vin in 0 SIN(0.45000000 0.44100000 2.50000000e+08)
Rsrc in afe 50
Csample afe 0 8.000000000000e-15
Iadc vdd 0 PULSE(0 2.300000000000e-02 0 2.500000000000e-12 2.500000000000e-12 4.500000000000e-11 2.500000000000e-10)

.control
set filetype=ascii
set wr_singlescale
set wr_vecnames
tran 7.812500000000e-12 3.200000000000e-08
wrdata experiments/results/runs/suds_tetc_adc_corner_cases_20260514_r12_reinforcement/ngspice/traces/adc8_sine_combined_stress.csv time v(in) v(afe) i(Vvdd)
quit
.endc

.end
