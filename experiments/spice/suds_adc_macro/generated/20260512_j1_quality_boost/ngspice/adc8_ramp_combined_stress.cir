* SUDS ADC macro sanity deck for ngspice
* Evidence label: spice_macro
* Boundary: behavioral/macro deck for ADC-tier energy calibration only.
* Not PDK, not extracted layout, not silicon, not measured hardware energy.

.param VDD=1.0
.param BITS=8
.param FS_GSPS=4
.param NCONV=128

Vvdd vdd 0 {VDD}
Vin in 0 PWL(0 0 3.200000000000e-08 1.0)
Rsrc in afe 50
Csample afe 0 8.000000000000e-15
Iadc vdd 0 PULSE(0 2.222222222222e-02 0 2.500000000000e-12 2.500000000000e-12 4.500000000000e-11 2.500000000000e-10)

.control
set filetype=ascii
set wr_singlescale
set wr_vecnames
tran 7.812500000000e-12 3.200000000000e-08
wrdata /Users/jk6k/Desktop/fyp/experiments/results/runs/suds_adc_macro_spice_20260512_j1_quality_boost/ngspice/traces/adc8_ramp_combined_stress.csv time v(in) v(afe) i(Vvdd)
quit
.endc

.end
