* SUDS ADC macro sanity deck for Xyce
* Evidence label: spice_macro
* Boundary: behavioral/macro deck for ADC-tier energy calibration only.
* Not PDK, not extracted layout, not silicon, not measured hardware energy.

.PARAM VDD=1.0
.PARAM BITS=4
.PARAM FS_GSPS=0.5
.PARAM NCONV=128

Vvdd vdd 0 {VDD}
Vin in 0 PWL(0 0 2.560000000000e-07 1.0)
Rsrc in afe 50
Csample afe 0 1.000000000000e-15
Iadc vdd 0 PULSE(0 1.736111111111e-04 0 2.000000000000e-11 2.000000000000e-11 3.600000000000e-10 2.000000000000e-09)

.TRAN 6.250000000000e-11 2.560000000000e-07
.PRINT TRAN FORMAT=CSV FILE="/Users/jk6k/Desktop/fyp/experiments/results/runs/suds_adc_macro_spice_20260512_j1_quality_boost/xyce/traces/adc4_ramp_low_rate.csv" TIME V(in) V(afe) I(Vvdd)
.END
